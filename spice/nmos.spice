* SPICE3 file created from nmos.ext - technology: sky130A

X0 CS CS GND GND sky130_fd_pr__nfet_01v8 ad=5 pd=7 as=5 ps=7 w=5 l=2
X1 GND CS IO GND sky130_fd_pr__nfet_01v8 ad=10 pd=14 as=5 ps=7 w=5 l=2
X2 CS CS GND GND sky130_fd_pr__nfet_01v8 ad=5 pd=7 as=5 ps=7 w=5 l=2
X3 GND CS CS GND sky130_fd_pr__nfet_01v8 ad=5 pd=7 as=5 ps=7 w=5 l=2
X4 IO CS GND GND sky130_fd_pr__nfet_01v8 ad=5 pd=7 as=10.00515 ps=14.02 w=5 l=2
X5 GND CS CS GND sky130_fd_pr__nfet_01v8 ad=5 pd=7 as=5 ps=7 w=5 l=2
X6 IO CS GND GND sky130_fd_pr__nfet_01v8 ad=5 pd=7 as=5 ps=7 w=5 l=2
X7 GND CS IO GND sky130_fd_pr__nfet_01v8 ad=5 pd=7 as=5 ps=7 w=5 l=2
C0 CS IO 2.0805f
C1 IO GND 7.37394f
C2 CS GND 19.5809f
